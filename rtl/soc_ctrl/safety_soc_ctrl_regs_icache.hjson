# Copyright 2023 ETH Zurich and University of Bologna
# Solderpad Hardware License, Version 0.51, see LICENSE for details.
# SPDX-License-Identifier: SHL-0.51

{
  name: "safety_soc_ctrl_icache",
  clock_primary: "clk_i",
  reset_primary: "rst_ni",
  bus_interfaces: [
    { protocol: "reg_iface",
      direction: "device"
    }
  ],

  regwidth: "32",
  registers: [
    { name: "bootaddr",
      desc: "Core Boot Address",
      swaccess: "rw",
      hwaccess: "hro",
      fields: [
        { bits: "31:0",
          name: "bootaddr",
          desc: "Boot Address",
          resval: 0x1A00_0000
        }
      ]

    },
    { name: "fetchen",
      desc: "Core Fetch Enable",
      swaccess: "rw",
      hwaccess: "hrw",
      fields: [
        { bits: "0",
          name: "fetchen",
          desc: "Fetch Enable",
          resval: 0
        }
      ]
    },
    { name: "corestatus",
      desc: "Core Return Status (return value, EOC)",
      swaccess: "rw",
      hwaccess: "hro",
      fields: [
        { bits: "31:0",
          name: "core_status",
          desc: "Core Return Status (EOC(bit[31]) and status(bit[30:0]))",
          resval: 0
        }
      ]
    },
    { name: "bootmode",
      desc: "Core Boot Mode",
      swaccess: "rw",
      hwaccess: "hrw",
      fields: [
        { bits: "1:0",
          name: "bootmode",
          desc: "Boot Mode",
          resval: 0x0
        }
      ]
    },
    { name: "icache_enable_prefetch",
      desc: "Enable iCache prefetching",
      swaccess: "rw",
      hwaccess: "hro",
      fields: [
        { bits: "0",
          name: "prefetch_enable",
          desc: "Enable prefetching",
          resval: 0x1
        }
      ]
    },
    { name: "icache_flush",
      desc: "Flush iCache",
      swaccess: "rw",
      hwaccess: "hrw",
      hwqe: "true",
      hwext: "true",
      fields: [
        { bits: "0",
          name: "flush",
          desc: "Flush",
          resval: 0x0
        }
      ]
    },
    { name: "icache_perfctr_ctrl",
      desc: "iCache Performance Counter Control",
      swaccess: "rw",
      hwaccess: "hrw",
      fields: [
        { bits: "0",
          name: "enable",
          desc: "Enable performance counters",
          resval: 0x1
        },
        { bits: "16",
          name: "clear_all",
          desc: "Clear all performance counters",
          resval: 0x0
        }
      ]
    },
    { multireg: {
        name: "counters",
        desc: "Performance counters",
        count: "9",
        cname: "id",
        swaccess: "rw0c",
        hwaccess: "hrw",
        fields: [
          { bits: "31:0",
            name: "counter",
            desc: "",
            resval: 0x0000_0000
          }
        ]
      }
    },
  ],
}
